(defun intValue (bits)
    (if (null bits)
        0
        ((car bits) + (2 * (intValue (cdr bits))))))

(defun snoc (values lastVal)
    (append values (list lastVal)))

(defun lengthenBitlist (bitlist size)
    (if ((length bitlist) < size)
        (lengthenBitlist (snoc bitlist 0) size)
        bitlist))

(defun explodeToBits (intValue)
    (if (equal intValue 0)
        nil
        (cons (mod intValue 2) (explodeToBits (intValue / 2)))))

(defun replicate (n a)
    (if (equal n 0)
        nil
        (cons a (replicate (n-1) a))))

(defun sum (xs)
    (if (null xs)
        0
        ((car xs) + (sum (cdr xs)))))

(defun increment (bits)
    (if (equal (car bits) 0)
        (cons 1 (cdr bits))
        (cons 0 (increment (cdr bits)))))

(defun permute (bits)
    (if (equal (sum bits) (length bits))
        (list bits)
        (cons bits (permute (increment bits)))))

(defun intToStr (n)
    (sprintf nil "%d" n))

(defun intListToStrList (intList)
    (mapcar 'intToStr intList))

(defun intListToStr (intList)
    (buildString (intListToStrList intList) " "))

; Return all permutations of n bits
(defun permutations (n)
    (permute (replicate n 0)))

(defun assignDesVars (values names)
    (if (or (null values) (null names))
        nil
        (progn
            pinName = (car names)
            pinValue = (car values)

            printf( "Assigning %s value %d\n" pinName pinValue)

            (desVar pinName pinValue)
            (assignDesVars (cdr values) (cdr names)))))

(defun verifyResults (inputs outputs)

    numOutBits = (length outputs)

    ; generate bitlist from targetFunc
    expected = (lengthenBitlist
                 (apply targetFunc inputs)
                 numOutBits)

    (if (equal expected outputs)
        t
        (printf "ERROR! inp = (%s), out = (%s), expected = (%s)\n"
            (intListToStr inputs)
            (intListToStr outputs)
            (intListToStr expected))))

(defun getSimOutputs ( outPins )
    (if (null outPins)
        nil
        (progn
            pinName = (car outPins)
            (cons (value (v pinName ?result "tran") END_TIME)
                  (getSimOutputs (cdr outPins))))))

; Note that inputLists is a list of input lists.
(defun testInputLists (inputPatterns inPins outPins)

    (defun threshFunc (voltage)
        (if (voltage > 4.5)
            1
            (if (voltage < 0.5)
                0
                (printf "ERROR! Bad voltage at %.2f Volts\n" voltage))))

    inValues = (car inputPatterns) ; Determine this configuration of inputs

    (assignDesVars inValues inPins); Instruct simulation which values to use
    (run)                          ; Run the simulation
    outVolts = (getSimOutputs outPins) ; Save the outputs
    outValues = (mapcar threshFunc outVolts)
    (verifyResults inValues outValues) ; Expected vs Observed

    ; Test all remaining input patterns
    (testInputLists (cdr inputPatterns) inPins outPins))
